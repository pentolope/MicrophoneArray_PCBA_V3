* scenario: board-a-5v-fused-link-drop
* deterministic deck generated by pcbqa.sim.ngspice
* model net:5V_FUSED@9ddb432333d3+phys:d284d6085f88 coverage=interconnect_dc:geometry-derived source=pcbqa.extract segment inventory
.subckt net:5V_FUSED@9ddb432333d3+phys:d284d6085f88 a b
R1 a b 0.002377496
.ends
Vhost vin 0 DC 5.0
Xlink vin vout net:5V_FUSED@9ddb432333d3+phys:d284d6085f88
Rdemand vout 0 50.0
.options temp=20.0
.control
set filetype=ascii
op
wrdata op_vout.data v(vout)
quit
.endc
.end
