* scenario: board-a-5v-fused-link-drop
* deterministic deck generated by pcbqa.sim.ngspice
* model net:5V_FUSED@9ddb432333d3+phys:49c4fed5a90f coverage=device_electrical:not-applicable,digital_io:not-applicable,functional_behavior:not-applicable,interconnect_dc:geometry-derived,interconnect_si:unsupported,power_integrity:unsupported source=pcbqa.extract segment inventory
.subckt net:5V_FUSED@9ddb432333d3+phys:49c4fed5a90f a b
R1 a b 0.002377496
.ends
Vhost vin 0 DC 5.0
Xlink vin vout net:5V_FUSED@9ddb432333d3+phys:49c4fed5a90f
Rdemand vout 0 50.0
.options temp=20.0
.control
set filetype=ascii
op
wrdata op_vout.data v(vout)
quit
.endc
.end
